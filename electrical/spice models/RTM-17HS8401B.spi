.SUBCKT RTM17HS8401B A1 A2 B1 B2

R1 A1 N001 1
L1 N001 A2 3.5m

R2 B1 N002 1
L2 N002 B2 3.5m

.ENDS RTM17HS8401B
